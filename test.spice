* Simple CMOS inverter test file
M1 out in vdd vdd pmos W=1u L=0.15u
M2 out in 0 0 nmos W=0.5u L=0.15u
R1 vdd out 10k
C1 out 0 10f
V1 vdd 0 DC 1.8
